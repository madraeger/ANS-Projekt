* Varactor library
.MODEL BB112 D ( IS=1e-14 RS=0.0011 CJO=2.324n VJ=0.75 TT=5n M=0.9 BV=100 XTI=3 FC=0.5 IBV=0.0001   )
.MODEL BB212 D ( IS=1e-14 RS=0.0011 CJO=7.202e-10 VJ=.10 TT=5n M=0.9 BV=100 XTI=3 FC=0.5 IBV=0.0001   )
.MODEL BB119 D IS=1.122e-17 RS=0.0011 CJO=4.163e-11 VJ=0.75 TT=5n M=0.3333 BV=100 N=1 EG=1.11 XTI=3 FC=0.5 IBV=0.0001 TNOM=27
.MODEL BB130 D IS=1e-14 RS=0.0011 CJO=5.563e-11 VJ=0.75 TT=5n M=0.3333 BV=100 N=1 EG=1.11 XTI=3 FC=0.5 IBV=0.0001 TNOM=27
.MODEL BB204B D IS=1e-14 RS=0.0011 CJO=7.783e-11 VJ=0.75 TT=5n M=0.4705 BV=100 N=1 EG=1.11 XTI=3 FC=0.5 IBV=0.0001 TNOM=27
.MODEL BB204G D IS=1e-14 RS=0.0011 CJO=8.431e-11 VJ=0.75 TT=5n M=0.4711 BV=100 N=1 EG=1.11 XTI=3 FC=0.5 IBV=0.0001 TNOM=27
.MODEL BB215 D IS=1e-14 RS=0.0011 CJO=3.249e-11 VJ=0.75 TT=5n M=0.7646 BV=100 N=1 EG=1.11 XTI=3 FC=0.5 IBV=0.0001 TNOM=27
.MODEL BB219 D IS=1e-14 RS=0.0011 CJO=6.351e-11 VJ=0.75 TT=5n M=0.8465 BV=100 N=1 EG=1.11 XTI=3 FC=0.5 IBV=0.0001 TNOM=27
.MODEL BB240 D IS=1e-14 RS=0.0011 CJO=2.479e-08 VJ=0.75 TT=5n M=0.77 BV=100 N=1 EG=1.11 XTI=3 FC=0.5 IBV=0.0001 TNOM=27
.MODEL BB241 D IS=1e-14 RS=0.0011 CJO=1.049e-10 VJ=0.75 TT=5n M=0.9987 BV=100 N=1 EG=1.11 XTI=3 FC=0.5 IBV=0.0001 TNOM=27
.MODEL BB249 D IS=1e-14 RS=0.0011 CJO=8.387e-11 VJ=0.75 TT=5n M=0.8022 BV=100 N=1 EG=1.11 XTI=3 FC=0.5 IBV=0.0001 TNOM=27
.MODEL BB405B D IS=1e-14 RS=0.0011 CJO=2.673e-11 VJ=1.922 TT=5n M=0.9446 BV=100 N=1 EG=1.11 XTI=3 FC=0.5 IBV=0.0001 TNOM=27
.MODEL BB417 D IS=1e-14 RS=0.0011 CJO=5.329e-11 VJ=0.75 TT=5n M=0.9343 BV=100 N=1 EG=1.11 XTI=3 FC=0.5 IBV=0.0001 TNOM=27
.MODEL BB515 D IS=1e-14 RS=0.0011 CJO=3.412e-11 VJ=0.75 TT=5n M=0.7712 BV=30.36 N=1 EG=1.11 XTI=3 FC=0.5 IBV=10 TNOM=27
.MODEL BB619 D IS=1e-14 RS=0.0011 CJO=8.244e-11 VJ=0.75 TT=5n M=0.9376 BV=30.36 N=1 EG=1.11 XTI=3 FC=0.5 IBV=10 TNOM=27
.MODEL BB620 D IS=1e-14 RS=0.0011 CJO=1.756e-10 VJ=0.75 TT=5n M=0.9 BV=30.36 N=1 EG=1.11 XTI=3 FC=0.5 IBV=10 TNOM=27
.MODEL BB804 D IS=1e-14 RS=0.0011 CJO=6.9e-11 VJ=0.75 TT=5n M=0.3333 BV=30.36 N=1 EG=1.11 XTI=3 FC=0.5 IBV=10 TNOM=27
.MODEL BB809 D IS=1e-14 RS=0.0011 CJO=8.387e-11 VJ=0.75 TT=5n M=0.8022 BV=30.36 N=1 EG=1.11 XTI=3 FC=0.5 IBV=10 TNOM=27
.MODEL BB811 D IS=1e-14 RS=0.0011 CJO=1.687e-11 VJ=0.75 TT=5n M=0.7681 BV=30.36 N=1 EG=1.11 XTI=3 FC=0.5 IBV=10 TNOM=27
.MODEL BB909A D IS=1e-14 RS=0.0011 CJO=3.725e-11 VJ=10 TT=5n M=0.9 BV=100 N=1 EG=1.11 XTI=3 FC=0.5 IBV=0.0001 TNOM=27
.MODEL BB909B D IS=1e-14 RS=0.0011 CJO=4.028e-11 VJ=10 TT=5n M=0.9 BV=100 N=1 EG=1.11 XTI=3 FC=0.5 IBV=0.0001 TNOM=27
.MODEL BB910 D IS=1e-14 RS=0.0011 CJO=5.92e-11 VJ=0.75 TT=5n M=0.8679 BV=100 N=1 EG=1.11 XTI=3 FC=0.5 IBV=0.0001 TNOM=27
.MODEL BB911 D IS=1e-14 RS=0.0011 CJO=1.049e-10 VJ=0.75 TT=5n M=0.9987 BV=100 N=1 EG=1.11 XTI=3 FC=0.5 IBV=0.0001 TNOM=27
.MODEL BB535/SIE D(IS=1.75E-15 N=1.043 RS=60E-3 XTI=3 EG=1.11 CJO=25.31E-12 M=1.064 VJ=3.022 FC=.5 BV=32 IBV=100E-9 TT=120E-9 )
.MODEL BB545/SIE D(IS=110.11E-15 RS=0.24545 N=1.2034 XTI=3 EG=1.11 CJo=38.264P M=0.87698 Vj=0.91294 FC=0 BV=30 IBV=5E-6 TT=80N )
.MODEL BB639/SIE D(IS=4E-15 N=1.035 RS=.12 XTI=3 EG=1.11 CJO=55.88E-12 M=1.286 VJ=2.922 FC=.5 BV=32 IBV=100E-9 TT=160E-9 )
.MODEL BB804/SIE D(IS=48F N=1.13 RS=.18 XTI=3 EG=1.11 CJO=80.6P M=.47 VJ=.8 FC=.5 BV=20 IBV=.1U TT=137N )
.MODEL BB814/SIE D(IS=7f N=1.012 RS=.18 XTI=3 EG=1.11 CJO=83.9p M=.775 VJ=1.6 FC=.5 BV=20 IBV=100n TT=137n )
.MODEL BB833/SIE D (IS=42.156E-15 N=1.1718 RS=.10785 XTI=3 EG=1.11 CJO=29.033E-12 M=0.90022 VJ=.39089 FC=.5 BV=32 IBV=5E-6 TT=120E-9 )
.MODEL BB914/SIE D(IS=10.00E-15 N=1.020 RS=.28 IKF=0 XTI=3 EG=1.11 CJO=75.54E-12 M=1.161 VJ=3.445 FC=.5 ISR=100E-12 NR=2 BV=20 IBV=100E-9 TT=137.0E-9 )
